ADE simulation setup
Run mode: Single Run, Sweeps and Corners
Tests:
  ee240c:q1b_switch:1: ee240c/q1b_switch/schematic, simulator spectre
